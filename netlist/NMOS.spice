** sch_path: /workspaces/usm-vlsi-tools/shared_xserver/simulations/Projects/IHP/IPD413_202501/xschem/Ayudantias/Ayudantia_3/Sym_NMOS.sch
*.subckt NMOS Vd Vs Vg
.subckt NMOS

M2 Vd Vg Vs Vs sg13_lv_nmos w=1.0u l=0.45u ng=1 m=1
**.ends
.end
