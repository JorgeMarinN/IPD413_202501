* Extracted by KLayout with SG13G2 LVS runset on : 29/06/2025 18:33

.SUBCKT Inv
M$1 \$2 \$6 \$1 \$1 sg13_lv_nmos L=0.45u W=30u AS=6.15p AD=6.15p PS=45.3u
+ PD=45.3u
M$31 \$2 \$7 \$8 \$8 sg13_lv_pmos L=0.45u W=3u AS=1.02p AD=0.57p PS=8.04u
+ PD=4.14u
M$32 \$8 \$9 \$2 \$8 sg13_lv_pmos L=0.45u W=3u AS=0.57p AD=0.57p PS=4.14u
+ PD=4.14u
M$33 \$2 \$10 \$8 \$8 sg13_lv_pmos L=0.45u W=3u AS=0.57p AD=0.57p PS=4.14u
+ PD=4.14u
M$34 \$8 \$11 \$2 \$8 sg13_lv_pmos L=0.45u W=3u AS=0.57p AD=0.57p PS=4.14u
+ PD=4.14u
M$35 \$2 \$12 \$8 \$8 sg13_lv_pmos L=0.45u W=3u AS=0.57p AD=0.57p PS=4.14u
+ PD=4.14u
M$36 \$8 \$13 \$2 \$8 sg13_lv_pmos L=0.45u W=3u AS=0.57p AD=0.57p PS=4.14u
+ PD=4.14u
M$37 \$2 \$14 \$8 \$8 sg13_lv_pmos L=0.45u W=3u AS=0.57p AD=0.57p PS=4.14u
+ PD=4.14u
M$38 \$8 \$15 \$2 \$8 sg13_lv_pmos L=0.45u W=3u AS=0.57p AD=0.57p PS=4.14u
+ PD=4.14u
M$39 \$2 \$16 \$8 \$8 sg13_lv_pmos L=0.45u W=3u AS=0.57p AD=0.57p PS=4.14u
+ PD=4.14u
M$40 \$8 \$17 \$2 \$8 sg13_lv_pmos L=0.45u W=3u AS=0.57p AD=1.02p PS=4.14u
+ PD=8.04u
.ENDS Inv
