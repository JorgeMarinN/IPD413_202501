** sch_path: /workspaces/usm-vlsi-tools/shared_xserver/simulations/Projects/IHP/IPD413_202501/xschem/Ayudantias/Ayudantia_3/Inv.sch
.subckt Inv IN OUT VDD VSS
*.PININFO VDD:B VSS:B OUT:O IN:I
M1 OUT IN VDD VDD sg13_lv_pmos l=0.45u w=1.0u ng=1 m=30
M2 OUT IN VSS VSS sg13_lv_nmos l=0.45u w=1.0u ng=1 m=30
.ends
.end
